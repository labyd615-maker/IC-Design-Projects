*** SPICE deck for cell INV{lay} from library Reliable_CMOS_PUF(1)
*** Layout tech: mocmos, foundry MOSIS
.OPTIONS DEFL=3UM DEFW=3UM DEFAD=70P DEFAS=70P RELTOL=0.01
.MODEL NMOS NMOS LEVEL=1
+KP=60E-6 VTO=0.7 GAMMA=0.3 LAMBDA=0.05 PHI=0.6
+TOX=40E-9 CGSO=2.0E-10 CGDO=2.0E-10 CJ=.2M
.MODEL PMOS PMOS LEVEL=1
+KP=20E-6 VTO=0.7 GAMMA=0.4 LAMBDA=0.05 PHI=0.6
+TOX=40E-9 CGSO=3.0E-10 CGDO=3.0E-10 CJ=.2M
*** TOP LEVEL CELL: INV{lay}
Mnmos@0 VOUT VIN gnd gnd NMOS L=0.6U W=1.5U AS=8.19P AD=3.398P PS=18.6U PD=7.65U
Mpmos@0 VOUT VIN vdd vdd PMOS L=0.6U W=3U AS=10.845P AD=3.398P PS=21.9U PD=7.65U
* --- test harness ---
.global gnd vdd
VDD vdd 0 DC 5
VIN VIN 0 PULSE(0 5 20n 1n 1n 100n 220n)
CLOAD VOUT 0 50f
.measure tran trise TRIG V(VOUT) VAL=0.5 RISE=1 TARG V(VOUT) VAL=4.5 RISE=1
.measure tran tfall TRIG V(VOUT) VAL=4.5 FALL=1 TARG V(VOUT) VAL=0.5 FALL=1
.measure tran tphl TRIG V(VIN) VAL=2.5 RISE=1 TARG V(VOUT) VAL=2.5 FALL=1
.measure tran tplh TRIG V(VIN) VAL=2.5 FALL=1 TARG V(VOUT) VAL=2.5 RISE=1
.tran 0.1n 0.44us
.END
